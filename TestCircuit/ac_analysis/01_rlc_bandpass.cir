* Series RLC Band-Pass Filter
* Textbook series-RLC band-pass tuned to f0 = 1 / (2*pi*sqrt(L*C))
* ~ 5.03 kHz with Q ~ 10. The output is tapped across the resistor
* so it peaks at the resonance frequency.
* Devices exercised: V (AC source), R, L, C.

.title Series RLC Band-Pass Filter

* --- AC test source: 1 V AC magnitude ---
Vin in 0 AC 1

* --- Series RLC from the source to ground ---
R1 in   out 10
L1 out  n2  1m
C1 n2   0   1u

* --- Analysis: 3 decades around the tuned frequency ---
.ac dec 40 100 1Meg

.MEASURE AC v_at_resonance FIND vdb(out) AT=5k

.end
