* VCVS (E) Summing Amplifier
* Demonstrates the SPICE E card as a weighted summer. E1 first
* produces 2*V(in1); Eadd then adds V(in2) by sensing the voltage
* between in2 and ground. The exact transfer is
* V(out) = 2*V(in1) + V(in2).
* Devices exercised: V, R, E (VCVS x2).

.title VCVS Summing Amplifier

* --- Two sinusoidal inputs at different frequencies ---
Vin1 in1 0 SIN(0 0.5 1k)
Vin2 in2 0 SIN(0 0.3 3k)

* --- Exact weighted sum: V(w1)=2*V(in1), V(out)=V(w1)+V(in2) ---
E1   w1  0  in1 0 2.0
Eadd out w1 in2 0 1.0

* --- Output load ---
Rload out 0 10k

* --- Analysis: several beat periods ---
.tran 10u 5m

.MEASURE TRAN v_out_max MAX V(out)
.MEASURE TRAN v_out_min MIN V(out)

.end
