* Symmetric Diode Clipper
* Two antiparallel 1N4148 diodes clamp the output directly to ground.
* A large sine is limited near the model's forward voltage, producing
* the textbook symmetric flat-top waveform.
* Devices exercised: V, R, D (×2).

.title Symmetric Diode Clipper
.include "../../../resources/models/ngspice/testcircuit_discrete.lib"

* --- Large-signal input ---
Vin   in    0     SIN(0 3 1k)

* --- Series resistor so the diodes have something to drop against ---
Rs    in    out   1k

* --- Positive and negative clamps ---
Dp    out   0     1N4148

Dn    0     out   1N4148

* --- Output load ---
Rload out   0     100k

* --- Analysis: several input cycles ---
.tran 10u 5m

.MEASURE TRAN v_clip_pos MAX V(out)
.MEASURE TRAN v_clip_neg MIN V(out)

.end
