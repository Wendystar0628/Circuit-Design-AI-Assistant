* Inverting Amplifier via Subcircuit
* An ideal op-amp subcircuit (built on a very-high-gain VCVS) is
* wrapped around an R-R feedback network to form a classic -10x
* inverting amplifier. AC sweep captures the closed-loop gain and
* the bandwidth rolled off by the finite open-loop gain of the
* subcircuit's internal VCVS.
* Devices exercised: V (AC), R, X (subcircuit instance),
*                    E inside the subckt body.

.title Inverting Amplifier (Subcircuit-Based)

* --- AC test source ---
Vin in 0 AC 1

* --- Inverting feedback network: Rin = 1k, Rf = 10k -> gain = -10 ---
Rin in  inv    1k
Rf  inv out    10k

* --- High-gain ideal op-amp subcircuit (single-pole roll-off) ---
.subckt IDEAL_OPAMP plus minus out
* Differential input to an internal high-gain VCVS
Eopamp out 0 plus minus 1Meg
.ends IDEAL_OPAMP

* --- Subckt instance: + input tied to ground, - to the inv node ---
Xopamp 0 inv out IDEAL_OPAMP

* --- Output load ---
Rload out 0 10k

* --- Analysis ---
.ac dec 20 1 10Meg

.MEASURE AC a_midband FIND vdb(out) AT=1k

.end
