* Inverting Amplifier via Single-Pole Op-Amp Subcircuit
* A finite-bandwidth op-amp subcircuit (built from a high-gain VCVS,
* a dominant-pole R-C node, and an output buffer) is
* wrapped around an R-R feedback network to form a classic -10x
* inverting amplifier. AC sweep captures the closed-loop gain and
* the bandwidth rolled off by the subcircuit's dominant-pole network.
* Devices exercised: V (AC), R, C, X (subcircuit instance),
*                    E inside the subckt body.

.title Single-Pole Op-Amp Inverting Amplifier

* --- AC test source ---
Vin in 0 AC 1

* --- Inverting feedback network: Rin = 1k, Rf = 10k -> gain = -10 ---
Rin in  inv    1k
Rf  inv out    10k

* --- 1e6 DC gain with a 10 Hz dominant pole and buffered output ---
.subckt SINGLE_POLE_OPAMP plus minus out
Egain drive 0 plus minus 1Meg
Rdom drive pole 1k
Cdom pole 0 15.9u
Eout out 0 pole 0 1.0
.ends SINGLE_POLE_OPAMP

* --- Subckt instance: + input tied to ground, - to the inv node ---
Xopamp 0 inv out SINGLE_POLE_OPAMP

* --- Output load ---
Rload out 0 10k

* --- Analysis ---
.ac dec 20 1 10Meg

.MEASURE AC a_midband FIND vdb(out) AT=1k
.MEASURE AC a_high_end FIND vdb(out) AT=1Meg

.end
