.title NMOS
M1 N001 N002 0 STW11NM80
V1 N001 0 0
V2 N002 0 0
.dc V1 0V 300V 10V V2 0V 30V 5V
.end
