.title amplifier circuit
V1 0 N005 12
V2 N004 0 SINE(0 1 1k)
V3 N003 0 12
XU1 0 N001 N003 N005 N002 LT1001
R1 N001 N004 1k
Rf N002 N001 10k
.tran 20ms
.end
