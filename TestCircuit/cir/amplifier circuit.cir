.title amplifier circuit
.subckt CAI_COMPAT_OPAMP_5 P1 P2 P3 P4 P5
E1 NDRV 0 P1 P2 1e6
R1 NDRV P5 1
R2 P5 0 1e9
R3 P3 0 1e12
R4 P4 0 1e12
.ends CAI_COMPAT_OPAMP_5
V1 0 N005 12
V2 N004 0 SINE(0 1 1k)
V3 N003 0 12
XU1 0 N001 N003 N005 N002 CAI_COMPAT_OPAMP_5
R1 N001 N004 1k
Rf N002 N001 10k
.tran 20u 20ms
.end
