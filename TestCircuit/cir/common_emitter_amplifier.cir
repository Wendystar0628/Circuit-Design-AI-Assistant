.title common_emitter_amplifier
V1 N002 0 SINE(0 20m 1k)
V2 N001 0 6V
RS N003 N002 1k
Rb1 N001 N004 24k
Rc N001 N005 2.7k
Rb2 N004 0 10k
Re N007 0 1k
C1 N004 N003 10
C2 0 N007 10
C3 N005 N006 10
Q1 N005 N004 N007 2N2222
R1 N006 0 3k
;tran 20m
.ac dec 101 1 200Meg
.end
