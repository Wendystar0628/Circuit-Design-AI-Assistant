.title differential_amplifier
M1 N004 N003 N007 2N7002
R1 N001 N005 10k
R2 N001 N004 10k
R3 N002 N003 10k
R4 N006 0 10k
V1 N002 0 SINE(0 10mV 1k)
V2 N001 0 12V
I1 N007 N008 2.577mA
V3 0 N008 12V
M2 N005 N006 N007 2N7002
;op
.tran 20m
.end
