.title inverting amplifier
XU1 N005 N001 N003 N006 N002 LT1001
V1 N003 0 12
V2 0 N006 12
V3 N004 0 SINE(0 10m 1k)
R1 N001 N004 10k
R2 N005 0 9.1k
RF N002 N001 100k
.tran 20ms
.end
