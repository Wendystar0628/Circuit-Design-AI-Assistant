.title inverting amplifier
.subckt CAI_COMPAT_OPAMP_5 P1 P2 P3 P4 P5
E1 NDRV 0 P1 P2 1e6
R1 NDRV P5 1
R2 P5 0 1e9
R3 P3 0 1e12
R4 P4 0 1e12
.ends CAI_COMPAT_OPAMP_5
XU1 N005 N001 N003 N006 N002 CAI_COMPAT_OPAMP_5
V1 N003 0 12
V2 0 N006 12
V3 N004 0 SINE(0 10m 1k)
R1 N001 N004 10k
R2 N005 0 9.1k
RF N002 N001 100k
.tran 20u 20ms
.end
