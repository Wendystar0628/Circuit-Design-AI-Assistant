.title multistage_amplifier
V1 N006 0 SINE(0 10m 1k 0 0 0)
V2 N001 0 12
M1 N004 N008 N009 2N7002
M2 N002 N004 N005 2N7002
RS N007 N006 1k
R2 N001 N008 240k
R3 N008 0 118k
R4 N001 N004 7.3k
R5 N009 0 1.8k
R6 N001 N002 8.5k
R7 N005 0 1k
RL N003 0 10k
C1 N008 N007 1
C2 N003 N002 1
.tran 20ms
.end
