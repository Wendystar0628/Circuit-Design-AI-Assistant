.title non-inverting amplifier
.subckt CAI_COMPAT_OPAMP_5 P1 P2 P3 P4 P5
E1 NDRV 0 P1 P2 1e6
R1 NDRV P5 1
R2 P5 0 1e9
R3 P3 0 1e12
R4 P4 0 1e12
.ends CAI_COMPAT_OPAMP_5
XU1 N005 N002 N001 N006 N003 CAI_COMPAT_OPAMP_5
V1 N004 0 SINE(0 10m 1k)
V2 N001 0 12
V3 0 N006 12
R1 N005 N004 9.1k
R2 N002 0 10k
R3 N003 N002 100k
.tran 20u 20ms
.end
