* CMOS Schmitt Trigger
* The canonical six-MOSFET CMOS Schmitt trigger. The input drives a
* stack of two NMOS pull-downs in series (Mn1 / Mn2) and two PMOS
* pull-ups in series (Mp1 / Mp2). Two feedback devices, Mnf (NMOS,
* gated by the output) and Mpf (PMOS, gated by the output), push the
* intermediate nodes toward the rail that the output has most
* recently reached, creating a hysteresis window around the nominal
* switching threshold.
*
* A slow triangle-wave input sweeps the threshold back and forth so
* the transient waveform clearly displays the difference between the
* rising-edge trigger point (VT+) and the falling-edge trigger
* point (VT-). The width of that window is the hysteresis.
* Devices exercised: V, M (PMOS BSS84 x3 + NMOS BSS123 x3), C.

.title CMOS Schmitt Trigger
.include "../../resources/models/ngspice/testcircuit_discrete.lib"

* --- Supply and slow triangle-wave input ---
Vdd vdd 0 DC 5
Vin in  0 PWL(0 0   1m 5   2m 0   3m 5   4m 0)

* ============================================================
* NMOS pull-down stack (Mn1 on top of Mn2)
* ============================================================
Mn1 out in ma BSS123
Mn2 ma  in 0  BSS123

* --- NMOS feedback: resists pull-down while the output is high ---
Mnf vdd out ma BSS123

* ============================================================
* PMOS pull-up stack (Mp1 on top of Mp2)
* ============================================================
Mp1 out in mb  BSS84
Mp2 mb  in vdd BSS84

* --- PMOS feedback: resists pull-up while the output is low ---
Mpf 0 out mb BSS84

* --- Output load ---
Cload out 0 5p

* --- Analysis: capture the full input sweep ---
.tran 2u 4m

.MEASURE TRAN v_out_low  AVG V(out) FROM=0.9m TO=1.1m
.MEASURE TRAN v_out_high AVG V(out) FROM=1.9m TO=2.1m
.MEASURE TRAN vt_plus  FIND V(in) WHEN V(out)=2.5 FALL=1
.MEASURE TRAN vt_minus FIND V(in) WHEN V(out)=2.5 RISE=1

.end
