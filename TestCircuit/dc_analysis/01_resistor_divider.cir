* Resistor Divider DC Sweep
* Simplest possible DC sweep: a 2:1 resistor divider whose tap
* voltage is recorded as the input voltage is swept.
* Devices exercised: V (voltage source), R (resistor).

.title Resistor Divider DC Sweep

* --- Source (swept by .dc) ---
Vin in 0 DC 0

* --- 2:1 divider ---
R1 in  tap 10k
R2 tap 0   10k

* --- Extend one step past 10 V so AT=10 is not a floating endpoint ---
.dc Vin 0 10.1 0.1

.MEASURE DC v_tap_at_5v  FIND V(tap) AT=5
.MEASURE DC v_tap_at_10v FIND V(tap) AT=10

.end
