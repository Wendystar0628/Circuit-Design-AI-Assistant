* Resistor Thermal Noise
* Simplest possible noise testbed: a single resistor's thermal
* (Johnson) noise spectral density measured at an open node.
* The `.noise` analysis reports both input-referred and output
* noise densities as a function of frequency.
* Devices exercised: V (AC test source), R.

.title Resistor Thermal Noise

* --- AC test source and sensed output node ---
Vin in 0 AC 1

* --- Pure resistive network from source to output to ground ---
R1 in  out 10k
R2 out 0   10k

* --- Noise analysis: V(out) is the output, V(in) the input source ---
* ngspice's .meas directive does not accept a NOISE analysis type, so
* the total integrated noise must be inspected directly from the
* onoise / inoise frequency-sweep output on the chart / raw-data tab
* rather than through a .measure card.
.noise V(out) Vin dec 20 1 10Meg

.end
