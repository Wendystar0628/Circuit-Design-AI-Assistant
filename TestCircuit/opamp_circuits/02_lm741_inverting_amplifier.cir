.title LM741 Inverting Amplifier
.include "../../resources/models/sub/LM741.lib"

VCC vcc 0 DC 15
VEE vee 0 DC -15
Vin in 0 AC 1

Rin in inv 1k
Rf out inv 10k
XU1 0 inv vcc vee out LM741
Rload out 0 10k

.ac dec 20 10 10Meg

.MEASURE AC av_low_end   FIND vdb(out) AT=100
.MEASURE AC av_midband   FIND vdb(out) AT=10k
.MEASURE AC av_high_end  FIND vdb(out) AT=1Meg

.end
