.title LM741 Inverting Amplifier

VCC vcc 0 DC 15
VEE vee 0 DC -15
Vin in 0 AC 1

Rin in inv 1k
Rf out inv 10k
XU1 0 inv vcc vee out LM741
Rload out 0 10k

.ac dec 20 10 1Meg
.end
