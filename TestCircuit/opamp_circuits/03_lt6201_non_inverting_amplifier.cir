.title LT6201 Non-Inverting Amplifier

VCC vcc 0 DC 5
VEE vee 0 DC -5
Vin in 0 AC 1

Rg fb 0 1k
Rf out fb 4k
XU1 in fb out vcc vee LT6201
Rload out 0 1k

.ac dec 30 1k 100Meg

.MEASURE AC av_low_end  FIND vdb(out) AT=10k
.MEASURE AC av_midband  FIND vdb(out) AT=1Meg
.MEASURE AC av_high_end FIND vdb(out) AT=50Meg

.end
