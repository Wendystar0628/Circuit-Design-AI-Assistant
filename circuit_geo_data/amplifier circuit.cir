.title Amplifier Circuit

V1 vee 0 DC -12
V2 in 0 SIN(0 1 1k)
V3 vcc 0 DC 12
R1 in inv 1K
Rf out inv 10K

.subckt IDEAL_OPAMP plus minus out vcc vee
Rplus plus 0 1T
Rminus minus 0 1T
Eop out 0 plus minus 1Meg
.ends IDEAL_OPAMP

XU1 0 inv out vcc vee IDEAL_OPAMP

.tran 10u 20m
.end
